* V6 — UCC27201 gate driver propagation delay validation (behavioral)
* Reference: UCC27201 datasheet (TI SLUSAR4)
*   t_PHL_HO (HI output high-to-low) typical 25 ns
*   t_PHL_LO (LO output high-to-low) typical 25 ns
*
* Behavioral model: HI output follows IN with 25ns rise + 25ns delay.
* Validate: simulated delay matches datasheet ±10% (22.5-27.5 ns).

V_DD vdd 0 12.0
* PWM input: 50% duty, 100 kHz
V_PWM in 0 PULSE(0 5 0 1n 1n 5u 10u)

* HI output channel — 25ns delay via RC + threshold
R_HI in tinh 1k
C_HI tinh 0 36p IC=0
* Output buffer: 12V when tinh > 2.5, else 0
B_HI ho 0 V = V(tinh) > 2.5 ? 12 : 0

.SAVE V(in) V(ho) V(tinh)
.TRAN 1n 20u UIC

.control
run
* Measure: time from IN rising edge (50% = 2.5V) to HO rising edge (50% = 6V)
meas tran in_rise WHEN V(in)=2.5 RISE=1
meas tran ho_rise WHEN V(ho)=6 RISE=1
let delay_ns = (ho_rise - in_rise) * 1e9
print in_rise ho_rise delay_ns
* Datasheet typ 25 ns
let predicted_ns = 25.0
let delta_pct = (delay_ns - predicted_ns) / predicted_ns * 100
print predicted_ns delta_pct
.endc
.end
